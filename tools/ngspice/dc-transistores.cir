* Amplificador emissor comum polarizado por divisor (NPN), espelho com PNP e chave MOSFET canal N
VCC 1 0 12
R1 1 2 47k
R2 2 0 10k
RC 1 3 2.2k
RE 4 0 1k
Q1 3 2 4 QN
VCC2 5 0 9
RE2 5 6 1k
Q2 0 7 6 QP
RB2 7 0 100k
VG 8 0 4
RD 9 10 10
VDD 9 0 12
M1 10 8 0 0 MN
VG2 11 0 2.7
RD2 9 12 100
M2 12 11 0 0 MN
.model QN NPN(IS=1e-14 BF=200 BR=2 VAF=100)
.model QP PNP(IS=1e-14 BF=200 BR=2 VAF=100)
.model MN NMOS(LEVEL=1 VTO=2.5 KP=5 LAMBDA=0.01 IS=1e-12)
.options reltol=1e-7 abstol=1e-14 vntol=1e-10
.control
set wr_singlescale
set wr_vecnames
op
wrdata out.txt v(2) v(3) v(4) v(6) v(7) v(10) v(12) i(VCC) i(VDD)
quit
.endc
.end
