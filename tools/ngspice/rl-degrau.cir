* Indutor com resistência de enrolamento: degrau de 5 V, L/R = 0,667 ms
V1 1 0 DC 5
R1 1 2 10
L1 2 3 10m ic=0
RL 3 0 5
.options reltol=1e-7 abstol=1e-14 vntol=1e-10
.control
set wr_singlescale
set wr_vecnames
tran 5u 4m 0 0.5u uic
linearize v(2) i(V1)
wrdata out.txt v(2) i(V1)
quit
.endc
.end
