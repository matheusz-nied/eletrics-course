* Circuito tanque LC paralelo excitado na ressonância (f0 = 1,59 kHz) por uma senoide com resistor em série
V1 1 0 SIN(0 5 1591.55)
R1 1 2 100
VL 2 4 DC 0
L1 4 0 1m ic=0
C1 2 0 10u ic=0
.options reltol=1e-7 abstol=1e-14 vntol=1e-10
.control
set wr_singlescale
set wr_vecnames
tran 5u 10m 0 0.2u uic
linearize v(2) i(V1) i(VL)
wrdata out.txt v(2) i(V1) i(VL)
quit
.endc
.end
