* Ponte de Wheatstone desbalanceada com fonte de corrente (ponto de operação CC)
V1 1 0 DC 12
R1 1 2 1k
R2 1 3 2.2k
R3 2 0 3.3k
R4 3 0 4.7k
R5 2 3 10k
I1 0 3 DC 1m
.options reltol=1e-9 abstol=1e-15 vntol=1e-12
.control
set wr_singlescale
set wr_vecnames
op
wrdata out.txt v(2) v(3) i(V1)
quit
.endc
.end
