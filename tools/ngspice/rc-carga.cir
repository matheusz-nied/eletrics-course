* Carga de capacitor: degrau de 10 V em RC = 1 ms, capacitor descarregado
V1 1 0 DC 10
R1 1 2 1k
C1 2 0 1u ic=0
.options reltol=1e-7 abstol=1e-14 vntol=1e-10
.control
set wr_singlescale
set wr_vecnames
tran 10u 5m 0 1u uic
linearize v(2) i(V1)
wrdata out.txt v(2) i(V1)
quit
.endc
.end
